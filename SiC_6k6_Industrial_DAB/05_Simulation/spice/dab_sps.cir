* 6.6 kW SiC DAB, SPS phi = 28.2 deg, generated by gen_spice.py
.param L=6.400e-05 n=2.0 fs=100000.0
V1 vhv 0 DC 800.0
R1s vhv vhv_i 0.3
C1 vhv_i 0 8.000e-05 ic=800.0
* LV port: battery-like source through 0.1 Ohm (bidirectional sink), link capacitor
V2 vlv 0 DC 400.0
R2s vlv vlv_i 0.1
C2 vlv_i 0 1.200e-04 ic=400.0
VgA1 gA1 0 PULSE(0 1 1.5000e-07 5n 5n 4.8500e-06 1.0000e-05)
SA1 vhv_i a gA1 0 SW_A
DA1 a vhv_i DBODY_A
CA1 vhv_i a 1.700e-10
VgA2 gA2 0 PULSE(0 1 5.1500e-06 5n 5n 4.8500e-06 1.0000e-05)
SA2 a 0 gA2 0 SW_A
DA2 0 a DBODY_A
CA2 a 0 1.700e-10
VgA3 gA3 0 PULSE(0 1 1.5000e-07 5n 5n 4.8500e-06 1.0000e-05)
SA3 b 0 gA3 0 SW_A
DA3 0 b DBODY_A
CA3 b 0 1.700e-10
VgA4 gA4 0 PULSE(0 1 5.1500e-06 5n 5n 4.8500e-06 1.0000e-05)
SA4 vhv_i b gA4 0 SW_A
DA4 b vhv_i DBODY_A
CA4 vhv_i b 1.700e-10
.model SW_A SW(Ron=0.052 Roff=1e7 Vt=0.5 Vh=0.1)
.model DBODY_A D(Is=1e-12 N=2.0 Rs=0.01 Cjo=1e-12)
* series inductor + ideal transformer (behavioural: Vp = n*Vs, Is = n*Ip)
Lser a p1 {L}
Ep p1 p2 value={ 2.0*v(s1,s2) }
Rp p2 b 20m
Gs s2 s1 value={ 2.0*i(Ep) }
Rs1 s1 0 1e9
Rs2 s2 0 1e9
VgB1 gB1 0 PULSE(0 1 9.3244e-07 5n 5n 4.8500e-06 1.0000e-05)
SB1 vlv_i s1 gB1 0 SW_B
DB1 s1 vlv_i DBODY_B
CB1 vlv_i s1 3.500e-10
VgB2 gB2 0 PULSE(0 1 5.9324e-06 5n 5n 4.8500e-06 1.0000e-05)
SB2 s1 0 gB2 0 SW_B
DB2 0 s1 DBODY_B
CB2 s1 0 3.500e-10
VgB3 gB3 0 PULSE(0 1 9.3244e-07 5n 5n 4.8500e-06 1.0000e-05)
SB3 s2 0 gB3 0 SW_B
DB3 0 s2 DBODY_B
CB3 s2 0 3.500e-10
VgB4 gB4 0 PULSE(0 1 5.9324e-06 5n 5n 4.8500e-06 1.0000e-05)
SB4 vlv_i s2 gB4 0 SW_B
DB4 s2 vlv_i DBODY_B
CB4 vlv_i s2 3.500e-10
.model SW_B SW(Ron=0.027 Roff=1e7 Vt=0.5 Vh=0.1)
.model DBODY_B D(Is=1e-12 N=2.0 Rs=0.01 Cjo=1e-12)
.tran 2n 4.000e-04 3.600e-04 2n uic
.control
run
set wr_singlescale
set wr_vecnames
wrdata /home/user/SiC-DC-DC-Converter/SiC_6k6_Industrial_DAB/05_Simulation/spice/dab_sps.csv v(a,b) v(s1,s2) i(Lser) v(a) v(s1) v(vhv_i) v(vlv_i) i(V1) i(V2)
quit
.endc
.end
